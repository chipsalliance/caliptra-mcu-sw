addrmap network_mbox_csr {
    desc="address maps for network mbox register space";
    littleendian = true;
    default hw = na;
    signal {activelow; async; cpuif_reset; field_reset;} rst_b;
    signal {activelow; async;} pwrgood;
    default resetsignal=rst_b;

    // NETWORK MBOX SRAM
    // Shall be first in memory map to reduce address waste.
    external mem {
        name = "Network Mailbox SRAM";
        desc = "Network Mailbox SRAM storage. The maximum size is 2MB, but is configurable by the integration team. Only writable once a lock is obtained. Cleared from 0x0 to max DLEN after lock is released.
        [br] Root user, user with lock on network mailbox, and target user have RW access.";
        sw = rw; 
        mementries = 524288;
        memwidth = 32; 
    } NETWORK_MBOX_SRAM;

    // lock register
    // set on read, indicate to network mailbox when modified
    // clear comes from network mailbox control
    reg {
        name="Network Mailbox Lock";
        desc="Network Mailbox lock register for network mailbox access, reading 0 will set the lock. On reset release lock is set to root_user (Network) to allow SRAM clearing";
        field {rset; sw=r; hw=r; hwset=true; hwclr=true; precedence=hw; swmod=true;} lock=0;
    } network_mbox_lock;

    // USER register
    // store AXI USER from interface when setting lock
    reg {
        name="Network Mailbox USER";
        desc="Stores the AXI USER that locked the network mailbox. Cleared when lock is cleared.";
        field {sw=r; hw=rw; we; hwclr;} user[32]=0;
    } network_mbox_user;
    
    // Target USER register
    reg {
        name="Network Mailbox Target USER";
        desc="Stores the AXI USER for target user access. Only valid when network_mbox_target_user_valid is set.  Only controllable by the root user. Only accessible when network mailbox is locked. Cleared when lock is cleared.";
        field {sw=rw; hw=r;hwclr; swwe=valid_root_req; } user[32]=0;
    } network_mbox_target_user;
    
    reg {
        name="Network Mailbox Target USER Valid";
        desc="Enables access for the network_mbox_target_user. Only controllable by the root user. Only accessible when network mailbox is locked. Cleared when lock is cleared.";
        field {sw=rw; hw=r;hwclr; swwe=valid_root_req; } valid=0;
    } network_mbox_target_user_valid;

    reg {
        name="Network Mailbox Command";
        desc="Command requested for data in network mailbox. Cleared when lock is cleared.";
        field {sw=rw;hwclr; swwe=valid_requester_req; } command[32]=0;
    } network_mbox_cmd;

    reg {
        name="Network Mailbox Data Length";
        desc="Data length for network mailbox access in bytes. Cleared when lock is cleared";
        field {sw=rw; hw=r; hwclr;  swwe=valid_requester_target_req; } length[32]=0;
    } network_mbox_dlen;

    reg {
        name="Network Mailbox Execute";
        desc="Network Mailbox execute register indicates to receiver that the sender is done. ";
        field {sw=rw; hw=r; swwe=valid_requester_req; swmod=true;} execute=0;
    } network_mbox_execute;

    reg {   name="Network Mailbox Target Status";
        desc="Status of the network mailbox command";
        field {
            name = "Network Mailbox Target Status";
            desc = "Indicates the status of network mailbox for the target user. Valid when done is set.";

            enum network_mbox_status_e {
                CMD_BUSY = 4'd0 {
                    desc = "Receiver is busy, command is not yet complete.";
                };
                DATA_READY = 4'd1 {
                    desc = "Requested data is ready in the network mailbox.";
                };
                CMD_COMPLETE = 4'd2 {
                    desc = "Requested command is complete.";
                };
                CMD_FAILURE = 4'd3 {
                    desc = "The requested command experienced a failure.";
                };
            };
            sw=rw; hw=r; swwe=valid_target_req; encode = network_mbox_status_e; hwclr; precedence=hw;} status[4]=0;
            field {
                name = "Network Mailbox Target Done";
                desc = "Indicates target user is done and target status is valid.";
                sw=rw; hwclr; hw=r; swwe=valid_target_req; precedence=hw; } done=0;
    } network_mbox_target_status;

    reg {  
        name="Network Mailbox Command Status";
        desc="Status of the network mailbox command";
        field {
            name = "Network Mailbox Status";
            desc = "Indicates the status of network mailbox command.";

            enum network_mbox_status_e {
                CMD_BUSY = 4'd0 {
                    desc = "Receiver is busy, command is not yet complete.";
                };
                DATA_READY = 4'd1 {
                    desc = "Requested data is ready in the network mailbox.";
                };
                CMD_COMPLETE = 4'd2 {
                    desc = "Requested command is complete.";
                };
                CMD_FAILURE = 4'd3 {
                    desc = "The requested command experienced a failure.";
                };
            };
            sw=rw; hw=r; swwe=valid_root_req; encode = network_mbox_status_e; hwclr; precedence=hw;} status[4]=0;
    } network_mbox_cmd_status;

    reg {  
        name="Network Mailbox HW Status";
        desc="HW status of the network mailbox";
        field {
            name = "Network Mailbox ECC Single Error";
            desc = "Indicates a correctable ECC single-bit error was
                    detected and corrected while reading dataout.
                    Auto-clears when network_mbox_execute field is cleared.";

            sw=r; hwset = true; hw=rw; wel; } ecc_single_error=1'b0;
        field {
            name = "Network Mailbox ECC Double Error";
            desc = "Indicates an uncorrectable ECC double-bit error
                    was detected while reading dataout.
                    Firmware developers are advised to set the command
                    status to CMD_FAILURE in response.
                    Auto-clears when network_mbox_execute field is cleared.";

            sw=r; hwset = true; hw=rw; wel; } ecc_double_error=1'b0;
    } network_mbox_hw_status;


};
