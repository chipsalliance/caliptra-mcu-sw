// SPDX-License-Identifier: Apache-2.0
//
// Licensed under the Apache License, Version 2.0 (the "License");
// you may not use this file except in compliance with the License.
// you may obtain a copy of the License at
//
// http://www.apache.org/licenses/LICENSE-2.0
//
// Unless required by applicable law or agreed to in writing, software
// distributed under the License is distributed on an "AS IS" BASIS,
// WITHOUT WARRANTIES OR CONDITIONS OF ANY KIND, either express or implied.
// See the License for the specific language governing permissions and
// limitations under the License.
//

// Address documentation for the externally implemented usb_ep0_hub_descr block.
// Imported from chipsalliance/usb2 commit 53bdc64ba14d28848ea737a858f24043dff6fe46
// and flattened to the 172-word Caliptra configuration.
addrmap usb_hub {
    name = "USB HUB Descriptor and SETUP Table Storage";
    desc = "Bus-visible HUB descriptor and SETUP-response table initialized from C_EP0_ROM. The live EP0 lookup path reads this software-accessible storage, so descriptor and SETUP-table writes affect subsequent USB responses. Word 15 controls HUB selection, connection, and self-powered reporting. While CONTROL.ENABLE and CONTROL.DCON are both one, descriptor and SETUP-table words are write-locked, but CONTROL remains writable so software can disconnect or disable the HUB and release the lock. The synchronized USB_EnableHub input continuously forces ENABLE and DCON to one while asserted. Word addresses at or above 172 within the rounded power-of-two bus aperture read zero and ignore writes while returning an OKAY bus response.";

    external mem {
        desc = "Software-readable and writable live table words 0 through 14. Reset restores the corresponding C_EP0_ROM words. Writes affect subsequent EP0 descriptor or SETUP responses and are ignored while CONTROL.ENABLE and CONTROL.DCON are both set.";
        mementries = 15;
        memwidth = 32;
        sw = rw;
    } DESCRIPTOR_LOW @ 0x00;

    reg {
        desc = "Controls selection of HUB mode, the upstream connection request, and self-powered reporting. CONTROL is always software-writable. Other implemented table words are write-locked while ENABLE and DCON are both one; clearing either field releases that lock unless USB_EnableHub remains asserted.";
        field {
            sw = rw;
            hw = rw;
            hwset = true;
            precedence = hw;
            desc = "Set to one to select the HUB as the upstream USB device and enable HUB-specific device and port routing. When zero, the upstream connection path uses Device 0 instead. The synchronized USB_EnableHub input continuously forces this field and DCON to one while asserted. This field remains software-writable while the table lock is active.";
        } ENABLE[0:0] = 0;
        field {
            sw = rw;
            hw = na;
            desc = "Stored and read back by the register interface but unused by HUB logic. Software should write zero.";
        } RESERVED_LOW[15:1] = 0;
        field {
            sw = rw;
            hw = rw;
            hwset = true;
            precedence = hw;
            desc = "Requests connection of the HUB device to the upstream USB bus. The effective HUB connection is DCON qualified by synchronized debounced VBUS and is selected upstream when ENABLE is one. The synchronized USB_EnableHub input continuously forces this field and ENABLE to one while asserted. This field remains software-writable while the table lock is active.";
        } DCON[16:16] = 0;
        field {
            sw = rw;
            hw = na;
            desc = "Stored and read back by the register interface but unused by HUB logic. Software should write zero.";
        } RESERVED_17[17:17] = 0;
        field {
            sw = rw;
            hw = r;
            desc = "Selects self-powered reporting when set. The effective self-powered state is this field OR the synchronized USB_self_powered pin. A change in the effective state overwrites the bmAttributes byte in table word 17 with 0xC0 for self-powered or 0x80 for bus-powered and, for the high-speed configuration, applies the same overwrite to table word 65. Other software-programmed bits in those bytes are not preserved across the update. The output consumed by HUB request handling is the registered effective state.";
        } SELF_POWERED[18:18] = 0;
        field {
            sw = rw;
            hw = na;
            desc = "Stored and read back by the register interface but unused by HUB logic. Software should write zero.";
        } RESERVED_HIGH[31:19] = 0;
    } CONTROL @ 0x3c;

    external mem {
        desc = "Software-readable and writable live table words 16 through 171, including descriptor data, SETUP match entries, and table link words. Reset restores the corresponding C_EP0_ROM words. Writes affect subsequent EP0 descriptor or SETUP responses and are ignored while CONTROL.ENABLE and CONTROL.DCON are both set. Changes in effective self-powered state overwrite the bmAttributes byte in word 17 and, for high-speed configuration, word 65.";
        mementries = 156;
        memwidth = 32;
        sw = rw;
    } DESCRIPTOR_HIGH @ 0x40;
};
