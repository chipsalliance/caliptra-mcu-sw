// SPDX-License-Identifier: Apache-2.0
//
// Licensed under the Apache License, Version 2.0 (the "License");
// you may not use this file except in compliance with the License.
// You may obtain a copy of the License at
//
// http://www.apache.org/licenses/LICENSE-2.0
//
// Unless required by applicable law or agreed to in writing, software
// distributed under the License is distributed on an "AS IS" BASIS,
// WITHOUT WARRANTIES OR CONDITIONS OF ANY KIND, either express or implied.
// See the License for the specific language governing permissions and
// limitations under the License.
//

regfile interface_regs {
    reg {
        default sw=r;
        default hw=r;

        field {
            desc = "Ascii \"CPTR\" to check that the image is valid.";
        } fpga_magic[32] = 32'h52545043;
    } fpga_magic;
    reg {
        default sw=r;
        default hw=rw;

        field {
            desc = "Git commit of HEAD the FPGA was built with.";
        } fpga_version[32] = 32'b0;
    } fpga_version;

    reg {
        field { sw=rw; hw=r; } cptra_pwrgood[0:0] = 1'b0;
        field { sw=rw; hw=r; } cptra_ss_rst_b[1:1] = 1'b0;

        field { sw=rw; hw=r; desc = "RSVD in SS"; } cptra_obf_uds_seed_vld[2:2] = 1'b0;
        field { sw=rw; hw=r; desc = "RSVD in SS"; } cptra_obf_field_entropy_vld[3:3] = 1'b0;

        field { sw=rw; hw=r; desc = "RSVD in SS"; } debug_locked[4:4] = 1'b0;
        field { sw=rw; hw=r; desc = "RSVD in SS"; } device_lifecycle[6:5] = 2'b0;
        field { sw=rw; hw=r; } bootfsm_brkpoint[7:7] = 1'b1;
        field { sw=rw; hw=r; desc = "Scan mode for Caliptra Core"; } scan_mode[8:8] = 1'b0;

        field { sw=rw; hw=r; desc = "RSVD in core"; } ss_debug_intent[16:16] = 1'b0;
        field { sw=rw; hw=r; desc = "RSVD in core"; } i3c_axi_user_id_filtering[17:17] = 1'b0;
        field { sw=rw; hw=r; desc = "RSVD in core"; } ocp_lock_en[18:18] = 1'b1;
        field { sw=rw; hw=r; desc = "RSVD in core"; } lc_Allow_RMA_or_SCRAP_on_PPD[19:19] = 1'b0;
        field { sw=rw; hw=r; desc = "RSVD in core"; } FIPS_ZEROIZATION_PPD[20:20] = 1'b0;

        field { sw=rw; hw=r; singlepulse=true; desc = "RSVD in core"; } trigger_axi_reset[31:31] = 1'b0;
    } control;

    reg {
        field { sw=r; hw=rw; desc = "RSVD in SS"; } cptra_error_fatal = 1'b0;
        field { sw=r; hw=rw; desc = "RSVD in SS"; } cptra_error_non_fatal = 1'b0;

        field { sw=r; hw=rw; desc = "RSVD in SS"; } ready_for_fuses = 1'b0;
        field { sw=r; hw=rw; desc = "RSVD in SS"; } ready_for_mb_processing = 1'b0;
        field { sw=r; hw=rw; desc = "RSVD in SS"; } ready_for_runtime = 1'b0;

        field { sw=r; hw=rw; desc = "RSVD in SS"; } mailbox_data_avail = 1'b0;
        field { sw=r; hw=rw; desc = "RSVD in SS"; } mailbox_flow_done = 1'b0;
    } status;

    reg {
        default sw=rw;
        default hw=r;

        field {
            desc = "USER Value passed to AXI Interconnect for transactions initiated from the ARM core";
        } arm_user[32] = 32'b0;
    } arm_user;

    reg {
        default sw=rw;
        default hw=r;

        field {} itrng_divisor[32] = 32'b0;
    } itrng_divisor;

    reg {
        default sw=r;
        default hw=rw;

        field {} cycle_count[32] = 32'b0;
    } cycle_count;

    reg {
        field { sw=rw; hw=r; } value[32] = 32'b0;
    } generic_input_wires[2] @0x30;

    reg {
        field { sw=r; hw=rw; } value[32] = 32'b0;
    } generic_output_wires[2];

    reg {
        default sw=rw;
        default hw=r;

        field {} value[32] = 32'b0;
    } cptra_obf_key[8] @0x40;

    reg {
        default sw=rw;
        default hw=r;

        field {} value[32] = 32'b0;
    } cptra_csr_hmac_key[16];

    reg {
        default sw=rw;
        default hw=r;

        field {} value[32] = 32'b0;
    } cptra_obf_uds_seed[16];

    reg {
        default sw=rw;
        default hw=r;

        field {} value[32] = 32'b0;
    } cptra_obf_field_entropy[8];


    reg {
        default sw=rw;
        default hw=r;

        field {
            desc = "SS USER Strap";
        } lsu_user[32] = 32'b0;
    } lsu_user;
    reg {
        default sw=rw;
        default hw=r;

        field {
            desc = "SS USER Strap";
        } ifu_user[32] = 32'b0;
    } ifu_user;
    reg {
        default sw=rw;
        default hw=r;

        field {
            desc = "SS USER Strap";
        } dma_axi_user[32] = 32'b0;
    } dma_axi_user;
    reg {
        default sw=rw;
        default hw=r;

        field {
            desc = "SS USER Strap";
        } soc_config_user[32] = 32'b0;
    } soc_config_user;
    reg {
        default sw=rw;
        default hw=r;

        field {
            desc = "SS USER Strap";
        } sram_config_user[32] = 32'b0;
    } sram_config_user;
    reg {
        default sw=rw;
        default hw=r;

        field {
            desc = "MCU Reset Vector Strap";
        } mcu_reset_vector[32] = 32'b0;
    } mcu_reset_vector;
    reg {
        field { sw=r; hw=rw; desc = "RSVD in core"; } ss_all_error_fatal = 1'b0;
        field { sw=r; hw=rw; desc = "RSVD in core"; } ss_all_error_non_fatal = 1'b0;
    } ss_all_error;
    reg {
        field { sw=rw; hw=r; } mcu_no_rom_config = 1'b0;
        field { sw=rw; hw=r; } cptra_ss_mci_boot_seq_brkpoint_i = 1'b0;
        field { sw=rw; hw=r; } cptra_ss_lc_Allow_RMA_on_PPD_i = 1'b0;
        field { sw=rw; hw=r; } cptra_ss_lc_ctrl_scan_rst_ni_i = 1'b0;
        field { sw=rw; hw=r; } cptra_ss_lc_esclate_scrap_state0_i = 1'b0;
        field { sw=rw; hw=r; } cptra_ss_lc_esclate_scrap_state1_i = 1'b0;

    } mcu_config;

    reg {
        default sw=rw;
        default hw=r;

        field {} uds_seed_base_addr[32] = 32'b0;
    } uds_seed_base_addr;
    reg {
        default sw=rw;
        default hw=r;

        field {} prod_debug_unlock_auth_pk_hash_reg_bank_offset[32] = 32'b0;
    } prod_debug_unlock_auth_pk_hash_reg_bank_offset;
    reg {
        default sw=rw;
        default hw=r;

        field {} num_of_prod_debug_unlock_auth_pk_hashes[32] = 32'b0;
    } num_of_prod_debug_unlock_auth_pk_hashes;

    reg {
        field { sw=rw; hw=r; } value[32] = 32'b0;
    } mci_generic_input_wires[2];

    reg {
        field { sw=r; hw=rw; } value[32] = 32'b0;
    } mci_generic_output_wires[2];

    reg {
        field { sw=r; hw=rw; desc = "RSVD in core"; } ss_key_release_base_addr[32] = 32'b0;
    } ss_key_release_base_addr;

    reg {
        field { sw=r; hw=rw; desc = "RSVD in core"; } ss_key_release_key_size[16] = 32'b0;
    } ss_key_release_key_size;

    reg {
        field { sw=r; hw=rw; desc = "RSVD in core"; } ss_external_staging_area_base_addr[32] = 32'b0;
    } ss_external_staging_area_base_addr;

    reg {
        field { sw=rw; hw=r; desc = "RSVD in core"; } cptra_ss_mcu_ext_int[31:3] = 29'b0;
    } cptra_ss_mcu_ext_int;

    reg {
        default sw=rw;
        default hw=r;

        field {} value[32] = 32'b0;
    } cptra_ss_raw_unlock_token_hash[4];

    reg {
        field { sw=rw; hw=na; } key[32] = 32'h0;
    } ocp_lock_key_release_reg[16] @ 0x200;
};

regfile flash_ctrl_regs {
    reg {
        field {
            sw = rw;
            hw = na;
            desc = "Error-related interrupts";
        } ERROR[0:0] = 1'b0;
        field {
            sw = rw;
            hw = na;
            desc = "Event-related interrupts";
        } EVENT[1:1] = 1'b0;
    } FL_INTERRUPT_STATE @ 0x00;

    reg {
        field {
            sw = rw;
            hw = na;
            desc = "Enable error interrupt";
        } ERROR[0:0] = 1'b0;
        field {
            sw = rw;
            hw = na;
            desc = "Enable event interrupt";
        } EVENT[1:1] = 1'b0;
    } FL_INTERRUPT_ENABLE @ 0x04;

    reg {
        field {
            sw = rw;
            hw = na;
            desc = "Page size in bytes (default 256)";
        } PAGE_SIZE[31:0] = 32'd256;
    } PAGE_SIZE @ 0x08;

    reg {
        field {
            sw = rw;
            hw = na;
            desc = "The page number for read, write, erase operations";
        } PAGE_NUM[31:0] = 32'b0;
    } PAGE_NUM @ 0x0C;

    reg {
        field {
            sw = rw;
            hw = na;
            desc = "The page buffer address for read/write operations (driver-provided memory address)";
        } PAGE_ADDR[31:0] = 32'b0;
    } PAGE_ADDR @ 0x10;

    reg {
        field {
            sw = rw;
            hw = na;
            desc = "\"0\" = Read page, \"1\" = Write Page, \"2\" = Erase Page";
        } OP[2:1] = 2'b0;
        field {
            sw = rw;
            hw = na;
            desc = "Start the operation. HW clears when done.";
        } START[0:0] = 1'b0;
    } FL_CONTROL @ 0x14;

    reg {
        field {
            sw = rw;
            hw = na;
            desc = "Flash operation error. \"1\" = Read Error, \"2\" = Write Error, \"4\" = Erase Error";
        } ERR[3:1] = 3'b0;
        field {
            sw = rw;
            hw = na;
            desc = "Flash operation done. Set by HW, cleared by SW";
        } DONE[0:0] = 1'b0;
    } OP_STATUS @ 0x18;

    reg {
        field {
            sw = rw;
            hw = na;
            desc = "Control register write enable. 1=unlocked, 0=locked during operation";
        } EN[0:0] = 1'b1;
    } CTRL_REGWEN @ 0x1C;

    reg {
        field {
            sw = rw;
            hw = na;
            desc = "Total flash size in bytes";
        } FLASH_SIZE[31:0] = 32'h0100_0000;
    } FLASH_SIZE @ 0x20;

    reg {
        field { sw=rw; hw=na; } FLASH_BUF[32] = 32'hffffffff;
        desc = "Flash buffer";
    } FLASH_BUF[64] @ 0x100;
};

regfile fifo_regs {
    reg {
        field { sw=r; hw=rw; rd_swacc=true; } next_char[8] = 8'b0;
        field { sw=r; hw=rw; } char_valid = 1'b0;
    } log_fifo_data;

    reg {
        field { sw=r; hw=rw; } log_fifo_empty = 1'b0;
        field { sw=r; hw=rw; } log_fifo_full = 1'b0;
    } log_fifo_status;

    reg {
        field { sw=rw; hw=r; wr_swacc=true; } itrng_data[32] = 32'b0;
    } itrng_fifo_data;

    reg {
        field { sw=r; hw=rw; } itrng_fifo_empty = 1'b0;
        field { sw=r; hw=rw; } itrng_fifo_full = 1'b0;
        field { sw=rw; hw=r; } itrng_fifo_reset = 1'b0;
    } itrng_fifo_status;

    reg {
        field { sw=r; hw=rw; rd_swacc=true; desc = "RSVD in core"; } out_data[32] = 32'b0;
    } dbg_fifo_pop;

    reg {
        field { sw=rw; hw=r; wr_swacc=true; desc = "RSVD in core"; } in_data[32] = 32'b0;
    } dbg_fifo_push;

    reg {
        field { sw=r; hw=rw; desc = "RSVD in core"; } dbg_fifo_empty = 1'b0;
        field { sw=r; hw=rw; desc = "RSVD in core"; } dbg_fifo_full = 1'b0;
    } dbg_fifo_status;

    reg {
        field { sw=r; hw=rw; rd_swacc=true; desc = "RSVD in core"; } out_data[32] = 32'b0;
    } msg_fifo_pop;

    reg {
        field { sw=rw; hw=r; wr_swacc=true; desc = "RSVD in core"; } in_data[32] = 32'b0;
    } msg_fifo_push;

    reg {
        field { sw=r; hw=rw; desc = "RSVD in core"; } msg_fifo_empty = 1'b0;
        field { sw=r; hw=rw; desc = "RSVD in core"; } msg_fifo_full = 1'b0;
    } msg_fifo_status;
};

addrmap caliptra_fpga_realtime_regs {
    default regwidth = 32;
    default accesswidth = 32;

    interface_regs interface_regs @ 0xA4010000;
    fifo_regs fifo_regs @ 0xA4011000;
    flash_ctrl_regs primary_flash_ctrl_regs @ 0xA4012000;
    flash_ctrl_regs secondary_flash_ctrl_regs @ 0xA4013000;
};
