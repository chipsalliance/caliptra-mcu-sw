// SPDX-License-Identifier: Apache-2.0
//
// Licensed under the Apache License, Version 2.0 (the "License");
// you may not use this file except in compliance with the License.
// You may obtain a copy of the License at
//
// http://www.apache.org/licenses/LICENSE-2.0
//
// Unless required by applicable law or agreed to in writing, software
// distributed under the License is distributed on an "AS IS" BASIS,
// WITHOUT WARRANTIES OR CONDITIONS OF ANY KIND, either express or implied.
// See the License for the specific language governing permissions and
// limitations under the License.
//

regfile interface_regs {
    reg {
        default sw=r;
        default hw=r;

        field {
            desc = "Ascii \"CPTR\" to check that the image is valid.";
        } fpga_magic[32] = 32'h52545043;
    } fpga_magic;
    reg {
        default sw=r;
        default hw=rw;

        field {
            desc = "Git commit of HEAD the FPGA was built with.";
        } fpga_version[32] = 32'b0;
    } fpga_version;

    reg {
        field { sw=rw; hw=r; } cptra_pwrgood[0:0] = 1'b0;
        field { sw=rw; hw=r; } cptra_ss_rst_b[1:1] = 1'b0;

        field { sw=rw; hw=r; } cptra_obf_uds_seed_vld[2:2] = 1'b0;
        field { sw=rw; hw=r; } cptra_obf_field_entropy_vld[3:3] = 1'b0;

        field { sw=rw; hw=r; } bootfsm_brkpoint[6:6] = 1'b0;
        field { sw=rw; hw=r; } ss_debug_intent[7:7] = 1'b0;
        field { sw=rw; hw=r; } i3c_axi_user_id_filtering[8:8] = 1'b0;
        field { sw=rw; hw=r; singlepulse=true; } trigger_axi_reset[31:31] = 1'b0;
    } control;

    reg {
        field { sw=r; hw=rw; } cptra_error_fatal = 1'b0;
        field { sw=r; hw=rw; } cptra_error_non_fatal = 1'b0;

        field { sw=r; hw=rw; } ready_for_fuses = 1'b0;
        field { sw=r; hw=rw; } ready_for_fw_push = 1'b0;
        field { sw=r; hw=rw; } ready_for_runtime = 1'b0;

        field { sw=r; hw=rw; } mailbox_data_avail = 1'b0;
        field { sw=r; hw=rw; } mailbox_flow_done = 1'b0;
    } status;

    reg {
        default sw=rw;
        default hw=r;

        field {
            desc = "USER Value passed to AXI Interconnect for transactions initiated from the ARM core";
        } arm_user[32] = 32'b0;
    } arm_user;

    reg {
        default sw=rw;
        default hw=r;

        field {} itrng_divisor[32] = 32'b0;
    } itrng_divisor;

    reg {
        default sw=r;
        default hw=rw;

        field {} cycle_count[32] = 32'b0;
    } cycle_count;

    reg {
        field { sw=rw; hw=r; } value[32] = 32'b0;
    } generic_input_wires[2] @0x30;

    reg {
        field { sw=r; hw=rw; } value[32] = 32'b0;
    } generic_output_wires[2];

    reg {
        default sw=rw;
        default hw=r;

        field {} value[32] = 32'b0;
    } cptra_obf_key[8] @0x40;

    reg {
        default sw=rw;
        default hw=r;

        field {} value[32] = 32'b0;
    } cptra_csr_hmac_key[16];

    reg {
        default sw=rw;
        default hw=r;

        field {} value[32] = 32'b0;
    } cptra_obf_uds_seed[16];

    reg {
        default sw=rw;
        default hw=r;

        field {} value[32] = 32'b0;
    } cptra_obf_field_entropy[8];


    reg {
        default sw=rw;
        default hw=r;

        field {
            desc = "SS USER Strap";
        } lsu_user[32] = 32'b0;
    } lsu_user;
    reg {
        default sw=rw;
        default hw=r;

        field {
            desc = "SS USER Strap";
        } ifu_user[32] = 32'b0;
    } ifu_user;
    reg {
        default sw=rw;
        default hw=r;

        field {
            desc = "SS USER Strap";
        } dma_axi_user[32] = 32'b0;
    } dma_axi_user;
    reg {
        default sw=rw;
        default hw=r;

        field {
            desc = "SS USER Strap";
        } soc_config_user[32] = 32'b0;
    } soc_config_user;
    reg {
        default sw=rw;
        default hw=r;

        field {
            desc = "SS USER Strap";
        } sram_config_user[32] = 32'b0;
    } sram_config_user;
    reg {
        default sw=rw;
        default hw=r;

        field {
            desc = "MCU Reset Vector Strap";
        } mcu_reset_vector[32] = 32'b0;
    } mcu_reset_vector;
    reg {
        field { sw=r; hw=rw; } mci_error_fatal = 1'b0;
        field { sw=r; hw=rw; } mci_error_non_fatal = 1'b0;
    } mci_error;
    reg {
        field { sw=rw; hw=r; } mcu_no_rom_config = 1'b0;
        field { sw=rw; hw=r; } cptra_ss_mci_boot_seq_brkpoint_i = 1'b0;
        field { sw=rw; hw=r; } cptra_ss_lc_Allow_RMA_on_PPD_i = 1'b0;
        field { sw=rw; hw=r; } cptra_ss_lc_ctrl_scan_rst_ni_i = 1'b0;
        field { sw=rw; hw=r; } cptra_ss_lc_esclate_scrap_state0_i = 1'b0;
        field { sw=rw; hw=r; } cptra_ss_lc_esclate_scrap_state1_i = 1'b0;
        
    } mcu_config;

    reg {
        default sw=rw;
        default hw=r;

        field {} uds_seed_base_addr[32] = 32'b0;
    } uds_seed_base_addr;
    reg {
        default sw=rw;
        default hw=r;

        field {} prod_debug_unlock_auth_pk_hash_reg_bank_offset[32] = 32'b0;
    } prod_debug_unlock_auth_pk_hash_reg_bank_offset;
    reg {
        default sw=rw;
        default hw=r;

        field {} num_of_prod_debug_unlock_auth_pk_hashes[32] = 32'b0;
    } num_of_prod_debug_unlock_auth_pk_hashes;
    
    reg {
        field { sw=rw; hw=r; } value[32] = 32'b0;
    } mci_generic_input_wires[2];

    reg {
        field { sw=r; hw=rw; } value[32] = 32'b0;
    } mci_generic_output_wires[2];

    reg {
        field { sw=rw; hw=na; } key[32] = 32'h0;
    } ocp_lock_key_release_reg[16] @ 0x200;
};

regfile fifo_regs {
    reg {
        field { sw=r; hw=rw; rd_swacc=true; } next_char[8] = 8'b0;
        field { sw=r; hw=rw; } char_valid = 1'b0;
    } log_fifo_data;

    reg {
        field { sw=r; hw=rw; } log_fifo_empty = 1'b0;
        field { sw=r; hw=rw; } log_fifo_full = 1'b0;
    } log_fifo_status;

    reg {
        field { sw=rw; hw=r; wr_swacc=true; } itrng_data[32] = 32'b0;
    } itrng_fifo_data;
    
    reg {
        field { sw=r; hw=rw; } itrng_fifo_empty = 1'b0;
        field { sw=r; hw=rw; } itrng_fifo_full = 1'b0;
        field { sw=rw; hw=r; } itrng_fifo_reset = 1'b0;
    } itrng_fifo_status;
    
    reg {
        field { sw=r; hw=rw; rd_swacc=true; } out_data[32] = 32'b0;
    } dbg_fifo_pop;

    reg {
        field { sw=rw; hw=r; wr_swacc=true; } in_data[32] = 32'b0;
    } dbg_fifo_push;

    reg {
        field { sw=r; hw=rw; } dbg_fifo_empty = 1'b0;
        field { sw=r; hw=rw; } dbg_fifo_full = 1'b0;
    } dbg_fifo_status;
    
    reg {
        field { sw=r; hw=rw; rd_swacc=true; } out_data[32] = 32'b0;
    } msg_fifo_pop;

    reg {
        field { sw=rw; hw=r; wr_swacc=true; } in_data[32] = 32'b0;
    } msg_fifo_push;

    reg {
        field { sw=r; hw=rw; } msg_fifo_empty = 1'b0;
        field { sw=r; hw=rw; } msg_fifo_full = 1'b0;
    } msg_fifo_status;
};

addrmap caliptra_fpga_realtime_regs {
    default regwidth = 32;
    default accesswidth = 32;

    interface_regs interface_regs @ 0xA4010000;
    fifo_regs fifo_regs @ 0xA4011000;
};
